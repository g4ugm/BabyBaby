| / 7\'7
| \ \   Xilinx Inc.
| / /
| \_\/.\   IBIS Models for Spartan-3E
[IBIS ver]   3.2
[File name]   ssem.ibs
[File Rev]   1.5
[Date]   Thu Jul 23 09:27:40 2015
[Source]   HSPICE simulations
[Notes]   IBIS models for Spartan-3E
[Disclaimer]
|   The data in this model is derived from SPICE simulations using
|   modeling information extracted from the target process. While
|   a great deal of care has been taken to provide information
|   that is accurate, this model is considered preliminary as it
|   has not been verified by actual silicon measurement. Treat the
|   data in this model as preliminary until actual silicon
|   verification is performed.
|   To accurately model package parasitics, please follow the
|   instructions at:  http://www.xilinx.com/xlnx/
|   xil_ans_display.jsp?getPagePath=11754
|   LVDS and LVPECL drivers require the use of external
|   termination resistors to provide the correct voltage levels.
|   For more information, refer to the Spartan-3 documentation.
|   NOTE: This file is compliant with IBIS Version 3.2, but it
|   may not implement all approved 3.2 features.
|   NOTE:  Newer versions of the buffer models may be available.
|   Check the web (http://www.xilinx.com/support/sw_ibis.htm) for
|   the latest file revision.  However, please be aware that the
|   web files are not compatible for use with IBISWriter, and
|   must be manually annotated, should their use be preferred.
[Copyright]
| Copyright 2006, Xilinx Inc., All rights reserved
|   Component Spartan-3E
[Component]   Spartan-3E
[Manufacturer]   Xilinx Inc.
[Package]
| For Package Type fg320
| variable   typ   min   max
R_pkg   279.84m   143.60m   397.60m
L_pkg   5.05nH   2.59nH   7.05nH
C_pkg   0.88pF   0.46pF   1.61pF
[Pin]  signal_name   model_name   R_pin   L_pin   C_pin
M15   PC_Data   LVCMOS25_S_12_I
T17   KC   LVCMOS25_S_12_I
R16   KAC   LVCMOS25_S_12_I
P17   KCC   LVCMOS25_S_12_I
T18   KSC   LVCMOS25_S_12_I
L17   PC_Write   LVCMOS25_S_12_I
R15   sw0   LVCMOS25_S_12_I
N17   sw6   LVCMOS25_S_12_I
R17   sw7   LVCMOS25_S_12_I
J13   halt_led   LVCMOS25_S_12_O
F17   led_anodes<0>   LVCMOS25_S_12_O
H17   led_anodes<1>   LVCMOS25_S_12_O
C18   led_anodes<2>   LVCMOS25_S_12_O
F15   led_anodes<3>   LVCMOS25_S_12_O
N8   green_out<1>   LVCMOS25_S_12_O
P8   green_out<2>   LVCMOS25_S_12_O
P6   green_out<3>   LVCMOS25_S_12_O
J14   leds<0>   LVCMOS25_S_12_O
J15   leds<1>   LVCMOS25_S_12_O
K15   leds<2>   LVCMOS25_S_12_O
K14   leds<3>   LVCMOS25_S_12_O
E16   leds<4>   LVCMOS25_S_12_O
P16   leds<5>   LVCMOS25_S_12_O
E4   leds<6>   LVCMOS25_S_12_O
P4   leds<7>   LVCMOS25_S_12_O
L15   pc_dash   LVCMOS25_S_12_O
L18   led_segs<0>   LVCMOS25_S_12_O
F18   led_segs<1>   LVCMOS25_S_12_O
D17   led_segs<2>   LVCMOS25_S_12_O
D16   led_segs<3>   LVCMOS25_S_12_O
G14   led_segs<4>   LVCMOS25_S_12_O
J17   led_segs<5>   LVCMOS25_S_12_O
H14   led_segs<6>   LVCMOS25_S_12_O
C17   led_segs<7>   LVCMOS25_S_12_O
T8   red_out   LVCMOS25_S_12_O
B8   clk50_in   LVCMOS25_S_12_I
B18   Load_button   LVCMOS25_S_12_I
U3   vs_out   LVCMOS25_S_12_O
M13   disp_sw<0>   LVCMOS25_S_12_I
R18   disp_sw<1>   LVCMOS25_S_12_I
K17   disp_sw<2>   LVCMOS25_S_12_I
U5   blue_out   LVCMOS25_S_12_O
M14   store_read   LVCMOS25_S_12_O
K12   pc_sync   LVCMOS25_S_12_O
T4   hs_out   LVCMOS25_S_12_O
H16   MCP_S_CLK   LVCMOS25_S_12_O
J12   MCP_T_CLK   LVCMOS25_S_12_O
M18   hooter   LVCMOS25_S_12_O
G15   MCP_S_CS   LVCMOS25_S_12_O
H15   MCP_T_CS   LVCMOS25_S_12_O
J16   MCP_S_SI   LVCMOS25_S_12_O
G13   MCP_S_SO   LVCMOS25_S_12_I
F14   MCP_T_SI   LVCMOS25_S_12_O
G16   MCP_T_SO   LVCMOS25_S_12_I
K13   PC_BUSY   LVCMOS25_S_12_O
B1   PROG_B   LVCMOS25_S_12
C1   IO_L01P_3   NC
C2   IO_L01N_3   NC
D1   IO_L02P_3   NC
D2   IO_L02N_3/VREF_3   NC
D3   IP   NC
D4   IO   NC
E2   IO_L03P_3   NC
E1   IO_L03N_3   NC
F4   IP   NC
E3   IO_L04N_3   NC
F5   IP   NC
F1   IO_L05P_3   NC
F2   IO_L05N_3   NC
G3   IO_L06P_3   NC
G4   IO_L06N_3/VREF_3   NC
G1   IP   NC
G6   IO_L07P_3   NC
G5   IO_L07N_3   NC
H6   IO_L08P_3   NC
H5   IO_L08N_3   NC
J7   IP   NC
H4   IO_L09P_3   NC
H3   IO_L09N_3   NC
H2   IO_L10P_3   NC
H1   IO_L10N_3   NC
J6   IP/VREF_3   NC
J5   LHCLK0   NC
J4   LHCLK1   NC
J1   LHCLK2   NC
J2   LHCLK3/IRDY2   NC
K2   IP   NC
K3   LHCLK4/TRDY2   NC
K4   LHCLK5   NC
K6   LHCLK6   NC
K5   LHCLK7   NC
K7   IP   NC
L1   IO_L15P_3   NC
L2   IO_L15N_3   NC
L3   IO_L16P_3   NC
L4   IO_L16N_3   NC
M1   IP   NC
L6   IO_L17P_3   NC
L5   IO_L17N_3/VREF_3   NC
M4   IO_L18P_3   NC
M3   IO_L18N_3   NC
N1   IP   NC
M5   IO_L19P_3   NC
M6   IO_L19N_3   NC
N4   IO_L20P_3   NC
N5   IO_L20N_3   NC
N2   IP   NC
P2   IO_L21P_3   NC
P1   IO_L21N_3   NC
R4   IP/VREF_3   NC
P3   IO_L22P_3   NC
R1   IP   NC
R3   IO_L23P_3   NC
R2   IO_L23N_3   NC
T2   IO_L24P_3   NC
T1   IO_L24N_3   NC
U1   IP   NC
V2   IP   NC
T3   INIT_B   LVCMOS25_S_12
V4   IP_L02P_2   NC
V3   IP_L02N_2   NC
U4   DOUT/BUSY   NC
R5   IO_L04P_2   NC
T5   IO_L04N_2   NC
R6   IO_L05P_2   NC
V5   IO_L06P_2   NC
V6   IO_L06N_2/VREF_2   NC
U6   IO   NC
N7   IO_L07P_2   NC
P7   IO_L07N_2   NC
V7   IO   NC
T7   IP_L08P_2   NC
R7   IP_L08N_2   NC
P9   IO   NC
R8   IO_L10P_2   NC
U8   IP_L11P_2   NC
V8   IP_L11N_2/VREF_2   NC
N9   D7/GCLK12   LVCMOS25_S_12
M9   D6/GCLK13   LVCMOS25_S_12
R9   D5   LVCMOS25_S_12
U9   D4/GCLK14   LVCMOS25_S_12
V9   D3/GCLK15   LVCMOS25_S_12
U10   RDWR_B/GCLK0   LVCMOS25_S_12
T10   M2/GCLK1   LVCMOS25_S_12
R10   D2/GCLK2   LVCMOS25_S_12
P10   D1/GCLK3   LVCMOS25_S_12
V11   M1   LVCMOS25_S_12
M10   M0   LVCMOS25_S_12
N10   DIN/D0   LVCMOS25_S_12
T11   IP_L17P_2   NC
U11   IP_L17N_2   NC
P11   IO_L18P_2   NC
N11   IO_L18N_2   NC
R11   IO   NC
V12   IO_L19P_2   NC
V13   IO_L19N_2/VREF_2   NC
T12   IO_L20P_2   NC
R12   IO_L20N_2   NC
U13   IO   NC
N12   IO_L21P_2   NC
P12   IO_L21N_2   NC
P13   A23   LVCMOS25_S_12
R13   A22   LVCMOS25_S_12
V14   IP_L23P_2   NC
U14   IP_L23N_2   NC
T14   A21   LVCMOS25_S_12
R14   A20   LVCMOS25_S_12
T15   IO/VREF_2   NC
V15   VS2/A19   NC
U15   VS1/A18   NC
V16   IP   NC
T16   VS0/A17   NC
U16   CCLK   LVCMOS25_S_12
V17   DONE   LVCMOS25_S_12
U18   A16   LVCMOS25_S_12
P15   IP   NC
N15   IO_L04P_1   NC
N14   IO_L04N_1   NC
P18   IO_L06N_1   NC
L14   IP   NC
M16   IO_L07N_1   NC
N18   IO_L08P_1   NC
L13   IP   NC
L16   A12   LVCMOS25_S_12
K18   IP   NC
H18   IP/VREF_1   NC
G18   IP   NC
H13   IP   NC
E18   IP   NC
E17   IP   NC
D18   IP/VREF_1   NC
E15   IO_L22P_1   NC
D15   TMS   LVCMOS25_S_12
C16   TDO   LVCMOS25_S_12
A17   TCK   LVCMOS25_S_12
C15   IP   NC
B16   IO_L01P_0   NC
A16   IO_L01N_0   NC
B15   IP_L02P_0   NC
A15   IP_L02N_0   NC
D14   IO_L03P_0   NC
C14   IO_L03N_0/VREF_0   NC
E13   IO   NC
B14   IO_L04P_0   NC
A14   IO_L04N_0   NC
A13   IO_L05P_0   NC
B13   IO_L05N_0/VREF_0   NC
D13   IO   NC
F12   IO_L06P_0   NC
E12   IO_L06N_0   NC
A12   IO   NC
C12   IP_L07P_0   NC
D12   IP_L07N_0   NC
E11   IO_L08P_0   NC
F11   IO_L08N_0   NC
A11   IO   NC
C11   IO_L09P_0   NC
D11   IO_L09N_0   NC
F10   IP_L10P_0   NC
G10   IP_L10N_0   NC
D10   GCLK4   NC
E10   GCLK5   NC
B11   IO/VREF_0   NC
B10   GCLK6   NC
A10   GCLK7   NC
B9   GCLK9   NC
C9   GCLK10   NC
D9   GCLK11   NC
G9   IO   NC
E9   IO_L15P_0   NC
F9   IO_L15N_0   NC
C8   IP_L16P_0   NC
D8   IP_L16N_0   NC
E8   IO_L17P_0   NC
F8   IO_L17N_0   NC
A8   IO   NC
C7   IO_L18P_0   NC
D7   IO_L18N_0/VREF_0   NC
F7   IO_L19P_0   NC
E7   IO_L19N_0/VREF_0   NC
A7   IO   NC
B6   IO_L20P_0   NC
A6   IO_L20N_0   NC
D6   IO_L21P_0   NC
E6   IO_L21N_0   NC
A5   IP_L22P_0   NC
B5   IP_L22N_0   NC
C5   IO_L23P_0   NC
D5   IO_L23N_0/VREF_0   NC
C4   IO   NC
A4   IO_L24P_0   NC
B4   IO_L24N_0   NC
A3   IP   NC
C3   IO_L25P_0   NC
B3   HSWAP   LVCMOS25_S_12
A2   TDI   LVCMOS25_S_12
A1   GND   GND
B2   GND   GND
A18   GND   GND
B17   GND   GND
V1   GND   GND
U2   GND   GND
V18   GND   GND
U17   GND   GND
C10   GND   GND
G7   GND   GND
G12   GND   GND
H8   GND   GND
H9   GND   GND
H10   GND   GND
H11   GND   GND
J8   GND   GND
K8   GND   GND
J11   GND   GND
K11   GND   GND
L8   GND   GND
L9   GND   GND
L10   GND   GND
L11   GND   GND
M7   GND   GND
M12   GND   GND
J3   GND   GND
K16   GND   GND
T9   GND   GND
B7   VCCAUX   POWER
B12   VCCAUX   POWER
G2   VCCAUX   POWER
M2   VCCAUX   POWER
G17   VCCAUX   POWER
M17   VCCAUX   POWER
U7   VCCAUX   POWER
U12   VCCAUX   POWER
A9   VCCO_0   POWER
C6   VCCO_0   POWER
C13   VCCO_0   POWER
G8   VCCO_0   POWER
G11   VCCO_0   POWER
J18   VCCO_1   POWER
F16   VCCO_1   POWER
N16   VCCO_1   POWER
H12   VCCO_1   POWER
L12   VCCO_1   POWER
V10   VCCO_2   POWER
T6   VCCO_2   POWER
T13   VCCO_2   POWER
M8   VCCO_2   POWER
M11   VCCO_2   POWER
K1   VCCO_3   POWER
F3   VCCO_3   POWER
N3   VCCO_3   POWER
H7   VCCO_3   POWER
L7   VCCO_3   POWER
E5   VCCINT   POWER
F6   VCCINT   POWER
E14   VCCINT   POWER
F13   VCCINT   POWER
N6   VCCINT   POWER
P5   VCCINT   POWER
N13   VCCINT   POWER
P14   VCCINT   POWER
| Models and submodels in the file (3): LVCMOS25_S_12 (I/O), LVCMOS25_S_12_I (Input), LVCMOS25_S_12_O (Output)
